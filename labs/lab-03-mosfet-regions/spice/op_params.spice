* AD103 Lab 03 - what the model itself thinks the parameters are
*
* Every number this deck prints, you will also have extracted yourself from a
* curve. The point is to put your extraction next to the model's own opinion
* and see how close two honest methods get.
*
* The syntax @m.<instance>.<model>[<param>] reaches inside the subcircuit that
* the sky130 symbol wraps around the real MOSFET. XMA in this deck becomes an
* internal device called m.xma.msky130_fd_pr__nfet_01v8 - that is why the name
* is so long, and why it is lower case.

.lib $PDK_ROOT/sky130A/libs.tech/ngspice/sky130.lib.spice.tt.red tt

XMA da g 0 0 sky130_fd_pr__nfet_01v8 L=1    W=5
XMB db g 0 0 sky130_fd_pr__nfet_01v8 L=1    W=10
XMC dc g 0 0 sky130_fd_pr__nfet_01v8 L=2    W=5
XMD dd g 0 0 sky130_fd_pr__nfet_01v8 L=0.15 W=1

Vgs g  0 1.8
Vda da 0 1.8
Vdb db 0 1.8
Vdc dc 0 1.8
Vdd dd 0 1.8

.control
op
echo
echo "--- drain current (A) ---"
print i(Vda) i(Vdb) i(Vdc) i(Vdd)
echo
echo "--- threshold voltage vth (V) ---"
print @m.xma.msky130_fd_pr__nfet_01v8[vth] @m.xmb.msky130_fd_pr__nfet_01v8[vth]
print @m.xmc.msky130_fd_pr__nfet_01v8[vth] @m.xmd.msky130_fd_pr__nfet_01v8[vth]
echo
echo "--- saturation voltage vdsat (V) ---"
print @m.xma.msky130_fd_pr__nfet_01v8[vdsat] @m.xmb.msky130_fd_pr__nfet_01v8[vdsat]
print @m.xmc.msky130_fd_pr__nfet_01v8[vdsat] @m.xmd.msky130_fd_pr__nfet_01v8[vdsat]
echo
echo "--- transconductance gm (S) ---"
print @m.xma.msky130_fd_pr__nfet_01v8[gm] @m.xmb.msky130_fd_pr__nfet_01v8[gm]
print @m.xmc.msky130_fd_pr__nfet_01v8[gm] @m.xmd.msky130_fd_pr__nfet_01v8[gm]
echo
echo "--- output conductance gds (S) ---"
print @m.xma.msky130_fd_pr__nfet_01v8[gds] @m.xmb.msky130_fd_pr__nfet_01v8[gds]
print @m.xmc.msky130_fd_pr__nfet_01v8[gds] @m.xmd.msky130_fd_pr__nfet_01v8[gds]

echo
echo "--- device A (W=5 L=1) at V_DS = 1.8 V, gate stepped ---"
foreach vg 0.6 0.9 1.2 1.5 1.8
  alter Vgs = $vg
  op
  echo "V_GS = $vg V"
  print @m.xma.msky130_fd_pr__nfet_01v8[vdsat] @m.xma.msky130_fd_pr__nfet_01v8[gm] @m.xma.msky130_fd_pr__nfet_01v8[gds]
end
.endc
.end
