* AD103 Lab 03 - W/L is a design knob
*
* Four transistors, identical bias, different shapes. Only the geometry
* changes. Watch what that does to the family of curves - and watch where the
* "current scales with W/L" rule you were taught stops being true.
*
*   A:  W=5   L=1     W/L = 5      the reference device
*   B:  W=10  L=1     W/L = 10     twice as wide
*   C:  W=5   L=2     W/L = 2.5    twice as long
*   D:  W=1   L=0.15  W/L = 6.67   minimum length - the one that misbehaves
*
* Each device has its own drain source so each can be swept on its own.

.lib $PDK_ROOT/sky130A/libs.tech/ngspice/sky130.lib.spice tt

XMA da g 0 0 sky130_fd_pr__nfet_01v8 L=1    W=5
XMB db g 0 0 sky130_fd_pr__nfet_01v8 L=1    W=10
XMC dc g 0 0 sky130_fd_pr__nfet_01v8 L=2    W=5
XMD dd g 0 0 sky130_fd_pr__nfet_01v8 L=0.15 W=1

Vgs g  0 1.8
Vda da 0 0
Vdb db 0 0
Vdc dc 0 0
Vdd dd 0 0

.control
dc Vda 0 1.8 0.01
dc Vdb 0 1.8 0.01
dc Vdc 0 1.8 0.01
dc Vdd 0 1.8 0.01

setplot dc1
let id_a = -dc1.i(vda)
let id_b = -dc2.i(vdb)
let id_c = -dc3.i(vdc)
let id_d = -dc4.i(vdd)

wrdata ../results/wl_sweep.txt id_a id_b id_c id_d
.endc
.end
