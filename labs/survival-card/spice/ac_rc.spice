* AD103 survival card, analysis 4 -- .ac, the frequency domain
* Printed on docs/reference/ngspice-errors.md, section "4. .ac"
* The SAME RC as tran_rc.spice. The two analyses and one hand calculation
* have to agree; rc_parts.spice measures the R and the C so you can check.
.lib $PDK_ROOT/sky130A/libs.tech/ngspice/sky130.lib.spice tt
Vin in 0 dc 0 ac 1
XR1 in out sky130_fd_pr__res_generic_po W=1 L=200
XC1 out 0 sky130_fd_pr__cap_mim_m3_1 W=10 L=10 MF=1 m=1
.control
ac dec 200 10k 1G
meas ac f3db when vdb(out)=-3.0103 fall=1
.endc
.end
