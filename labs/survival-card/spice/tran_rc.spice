* AD103 survival card, analysis 3 -- .tran, the time domain
* Printed on docs/reference/ngspice-errors.md, section "3. .tran"
* An RC with both parts drawn in SKY130. 1.1376 V is 0.632 x 1.8, so the
* measured time is one time constant AFTER THE EDGE AT 1 ns -- subtract it.
.lib $PDK_ROOT/sky130A/libs.tech/ngspice/sky130.lib.spice tt
Vin in 0 pulse(0 1.8 1n 10p 10p 50n 100n)
XR1 in out sky130_fd_pr__res_generic_po W=1 L=200
XC1 out 0 sky130_fd_pr__cap_mim_m3_1 W=10 L=10 MF=1 m=1
.control
tran 5p 40n
meas tran tau when v(out)=1.1376 rise=1
meas tran vfinal find v(out) at=39n
.endc
.end
