* AD103 Lab 01 - which model bin did my device land in?
*
* The same transistor as nmos_op.spice, with one deliberate difference: there
* is NO .control block. In batch mode that makes ngspice dump the entire
* operating point - including the model card it chose and the geometry it
* actually used - instead of only what you asked it to print.
*
* It is several hundred lines. `make bins` pulls out the eleven that matter.
* Read them on the reference page:
*   docs/reference/sky130-device-guide.md, "Your device is in a bin"

.lib $PDK_ROOT/sky130A/libs.tech/ngspice/sky130.lib.spice tt
XM1 d g 0 0 sky130_fd_pr__nfet_01v8 L=0.15 W=1
Vgs g 0 1.8
Vds d 0 1.8
.op
.end
